addrmap top {
    reg {
        field {} reserved;
    } top_reg;
};
